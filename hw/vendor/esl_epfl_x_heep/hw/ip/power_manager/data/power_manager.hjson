// Copyright lowRISC contributors.
// Licensed under the Apache License, Version 2.0, see LICENSE for details.
// SPDX-License-Identifier: Apache-2.0
{ name: "power_manager",
  clock_primary: "clk_i",
  bus_interfaces: [
    { protocol: "reg_iface", direction: "device" }
  ],
  regwidth: "32",
  registers: [
    { name:     "WAKEUP_STATE",
      desc:     "Wake-up state of the system",
      resval:   "0x00000000"
      swaccess: "rw",
      hwaccess: "hro",
      fields: [
        { bits: "0", name: "WAKEUP_STATE", desc: "Wake-up state Reg, used by BOOTROM" }
      ]
    }

    { name:     "RESTORE_ADDRESS",
      desc:     "Restore address value",
      resval:   "0x00000000"
      swaccess: "rw",
      hwaccess: "hro",
      fields: [
        { bits: "31:0", name: "RESTORE_ADDRESS", desc: "Restore address Reg, used by BOOTROM" }
      ]
    }

    { name:     "GLOBAL_POINTER",
      desc:     "Global Pointer value",
      resval:   "0x00000000"
      swaccess: "rw",
      hwaccess: "hro",
      fields: [
        { bits: "31:0", name: "GLOBAL_POINTER", desc: "Global Reg, used by power manager HAL" }
      ]
    }

    { name:     "EN_WAIT_FOR_INTR",
      desc:     "Enable wait for interrupt",
      resval:   "0x00000000"
      swaccess: "rw",
      hwaccess: "hro",
      fields: [
        { bits: "31:0", name: "EN_WAIT_FOR_INTR", desc: "Enable wait for interrupt" }
      ]
    }

    { name:     "INTR_STATE",
      desc:     "Interrupt state",
      resval:   "0x00000000"
      swaccess: "rw",
      hwaccess: "hrw",
      fields: [
        { bits: "31:0", name: "INTR_STATE", desc: "Interrupt state Reg" }
      ]
    }

    { name:     "POWER_GATE_CORE",
      desc:     "Used to power gate core",
      resval:   "0x00000000"
      swaccess: "rw",
      hwaccess: "hro",
      fields: [
        { bits: "0", name: "POWER_GATE_CORE", desc: "Power Gate Core Reg" }
      ]
    }

    { name:     "POWER_GATE_CORE_ACK",
      desc:     "Used by the core switch to ack the power manager",
      resval:   "0x00000000"
      swaccess: "ro",
      hwaccess: "hrw",
      fields: [
        { bits: "0", name: "POWER_GATE_CORE_ACK", desc: "Power Gate Core Ack Reg" }
      ]
    }

    { name:     "CPU_RESET_ASSERT_COUNTER",
      desc:     "Counter before resetting the CPU domain",
      resval:   "0x00000000"
      swaccess: "rw",
      hwaccess: "hrw",
      fields: [
        { bits: "31:0", name: "CPU_RESET_ASSERT_COUNTER", desc: "CPU counter before resetting" }
      ]
    }

    { name:     "CPU_RESET_DEASSERT_COUNTER",
      desc:     "Counter before unreset the CPU domain",
      resval:   "0x00000000"
      swaccess: "rw",
      hwaccess: "hrw",
      fields: [
        { bits: "31:0", name: "CPU_RESET_DEASSERT_COUNTER", desc: "CPU counter before unresetting" }
      ]
    }

    { name:     "CPU_SWITCH_OFF_COUNTER",
      desc:     "Counter before switching off the CPU domain",
      resval:   "0x00000000"
      swaccess: "rw",
      hwaccess: "hrw",
      fields: [
        { bits: "31:0", name: "CPU_SWITCH_OFF_COUNTER", desc: "CPU counter before switching off" }
      ]
    }

    { name:     "CPU_SWITCH_ON_COUNTER",
      desc:     "Counter before switching on the CPU domain",
      resval:   "0x00000000"
      swaccess: "rw",
      hwaccess: "hrw",
      fields: [
        { bits: "31:0", name: "CPU_SWITCH_ON_COUNTER", desc: "CPU counter before switching on" }
      ]
    }

    { name:     "CPU_WAIT_ACK_SWITCH_ON_COUNTER",
      desc:     "Bit to set whether to further wait for the ACK from the core switch after the counter expired",
      resval:   "0x00000000"
      swaccess: "rw",
      hwaccess: "hro",
      fields: [
        { bits: "0", name: "CPU_WAIT_ACK_SWITCH_ON_COUNTER", desc: "wait for CPU switch ack before switching on" }
      ]
    }

    { name:     "CPU_ISO_OFF_COUNTER",
      desc:     "Counter before setting off the isolation of the CPU domain",
      resval:   "0x00000000"
      swaccess: "rw",
      hwaccess: "hrw",
      fields: [
        { bits: "31:0", name: "CPU_ISO_OFF_COUNTER", desc: "CPU counter before setting off isolation" }
      ]
    }

    { name:     "CPU_ISO_ON_COUNTER",
      desc:     "Counter before setting on the isolation of the CPU domain",
      resval:   "0x00000000"
      swaccess: "rw",
      hwaccess: "hrw",
      fields: [
        { bits: "31:0", name: "CPU_ISO_ON_COUNTER", desc: "CPU counter before setting on isolation" }
      ]
    }

    { name:     "CPU_COUNTERS_STOP",
      desc:     "Bits to stop the counters keeping the done_o signal high",
      resval:   "0x00000000"
      swaccess: "rw",
      hwaccess: "hro",
      fields: [
        { bits: "0", name: "CPU_RESET_ASSERT_STOP_BIT_COUNTER", desc: "Stop the CPU_RESET_ASSERT_COUNTER counter" }
        { bits: "1", name: "CPU_RESET_DEASSERT_STOP_BIT_COUNTER", desc: "Stop the CPU_RESET_DEASSERT_COUNTER counter" }
        { bits: "2", name: "CPU_SWITCH_OFF_STOP_BIT_COUNTER", desc: "Stop the CPU_SWITCH_OFF_COUNTER counter" }
        { bits: "3", name: "CPU_SWITCH_ON_STOP_BIT_COUNTER", desc: "Stop the CPU_SWITCH_ON_COUNTER counter" }
        { bits: "4", name: "CPU_ISO_OFF_STOP_BIT_COUNTER", desc: "Stop the CPU_ISO_OFF_COUNTER counter" }
        { bits: "5", name: "CPU_ISO_ON_STOP_BIT_COUNTER", desc: "Stop the CPU_ISO_ON_COUNTER counter" }
      ]
    }

    { name:     "POWER_GATE_PERIPH_ACK",
      desc:     "Used by the periph switch to ack the power manager",
      resval:   "0x00000000"
      swaccess: "ro",
      hwaccess: "hrw",
      fields: [
        { bits: "0", name: "POWER_GATE_PERIPH_ACK", desc: "Power Gate Periph Ack Reg" }
      ]
    }

    { name:     "PERIPH_RESET",
      desc:     "Reset the PERIPH domain",
      resval:   "0x00000000"
      swaccess: "rw",
      hwaccess: "hro",
      fields: [
        { bits: "0", name: "PERIPH_RESET", desc: "Reset PERIPH domain" }
      ]
    }

    { name:     "PERIPH_SWITCH",
      desc:     "Switch off the PERIPH domain",
      resval:   "0x00000000"
      swaccess: "rw",
      hwaccess: "hro",
      fields: [
        { bits: "0", name: "PERIPH_SWITCH", desc: "Switch off PERIPH domain" }
      ]
    }

    { name:     "PERIPH_WAIT_ACK_SWITCH_ON",
      desc:     "Wait for the PERIPH domain switch ack",
      resval:   "0x00000000"
      swaccess: "rw",
      hwaccess: "hro",
      fields: [
        { bits: "0", name: "PERIPH_WAIT_ACK_SWITCH_ON", desc: "Wait PERIPH domain switch ack" }
      ]
    }

    { name:     "PERIPH_ISO",
      desc:     "Set on the isolation of the PERIPH domain",
      resval:   "0x00000000"
      swaccess: "rw",
      hwaccess: "hro",
      fields: [
        { bits: "0", name: "PERIPH_ISO", desc: "Set on isolation of PERIPH domain" }
      ]
    }

    { name:     "PERIPH_CLK_GATE",
      desc:     "Clock-gates the PERIPH domain",
      resval:   "0x00000000"
      swaccess: "rw",
      hwaccess: "hro",
      fields: [
        { bits: "0", name: "PERIPH_CLK_GATE", desc: "Clock-gates the PERIPH domain" }
      ]
    }


    { name:     "RAM_0_CLK_GATE",
      desc:     "Clock-gates the RAM_0 domain",
      resval:   "0x00000000"
      swaccess: "rw",
      hwaccess: "hro",
      fields: [
        { bits: "0", name: "RAM_0_CLK_GATE", desc: "Clock-gates the RAM_0 domain" }
      ]
    }

    { name:     "POWER_GATE_RAM_BLOCK_0_ACK",
      desc:     "Used by the ram 0 switch to ack the power manager",
      resval:   "0x00000000"
      swaccess: "ro",
      hwaccess: "hrw",
      fields: [
        { bits: "0", name: "POWER_GATE_RAM_BLOCK_0_ACK", desc: "Power Gate Ram Block 0 Ack Reg" }
      ]
    }

    { name:     "RAM_0_SWITCH",
      desc:     "Switch off the RAM_0 domain",
      resval:   "0x00000000"
      swaccess: "rw",
      hwaccess: "hro",
      fields: [
        { bits: "0", name: "RAM_0_SWITCH", desc: "Switch off RAM_0 domain" }
      ]
    }

    { name:     "RAM_0_WAIT_ACK_SWITCH_ON",
      desc:     "Wait for the RAM_0 domain switch ack",
      resval:   "0x00000000"
      swaccess: "rw",
      hwaccess: "hro",
      fields: [
        { bits: "0", name: "RAM_0_WAIT_ACK_SWITCH_ON", desc: "Wait RAM_0 domain switch ack" }
      ]
    }

    { name:     "RAM_0_ISO",
      desc:     "Set on the isolation of the RAM_0 domain",
      resval:   "0x00000000"
      swaccess: "rw",
      hwaccess: "hro",
      fields: [
        { bits: "0", name: "RAM_0_ISO", desc: "Set on isolation of RAM_0 domain" }
      ]
    }

    { name:     "RAM_0_RETENTIVE",
      desc:     "Set on retentive mode for the RAM_0 domain",
      resval:   "0x00000000"
      swaccess: "rw",
      hwaccess: "hro",
      fields: [
        { bits: "0", name: "RAM_0_RETENTIVE", desc: "Set on retentive mode for RAM_0 domain" }
      ]
    }

    { name:     "RAM_1_CLK_GATE",
      desc:     "Clock-gates the RAM_1 domain",
      resval:   "0x00000000"
      swaccess: "rw",
      hwaccess: "hro",
      fields: [
        { bits: "0", name: "RAM_1_CLK_GATE", desc: "Clock-gates the RAM_1 domain" }
      ]
    }

    { name:     "POWER_GATE_RAM_BLOCK_1_ACK",
      desc:     "Used by the ram 1 switch to ack the power manager",
      resval:   "0x00000000"
      swaccess: "ro",
      hwaccess: "hrw",
      fields: [
        { bits: "0", name: "POWER_GATE_RAM_BLOCK_1_ACK", desc: "Power Gate Ram Block 1 Ack Reg" }
      ]
    }

    { name:     "RAM_1_SWITCH",
      desc:     "Switch off the RAM_1 domain",
      resval:   "0x00000000"
      swaccess: "rw",
      hwaccess: "hro",
      fields: [
        { bits: "0", name: "RAM_1_SWITCH", desc: "Switch off RAM_1 domain" }
      ]
    }

    { name:     "RAM_1_WAIT_ACK_SWITCH_ON",
      desc:     "Wait for the RAM_1 domain switch ack",
      resval:   "0x00000000"
      swaccess: "rw",
      hwaccess: "hro",
      fields: [
        { bits: "0", name: "RAM_1_WAIT_ACK_SWITCH_ON", desc: "Wait RAM_1 domain switch ack" }
      ]
    }

    { name:     "RAM_1_ISO",
      desc:     "Set on the isolation of the RAM_1 domain",
      resval:   "0x00000000"
      swaccess: "rw",
      hwaccess: "hro",
      fields: [
        { bits: "0", name: "RAM_1_ISO", desc: "Set on isolation of RAM_1 domain" }
      ]
    }

    { name:     "RAM_1_RETENTIVE",
      desc:     "Set on retentive mode for the RAM_1 domain",
      resval:   "0x00000000"
      swaccess: "rw",
      hwaccess: "hro",
      fields: [
        { bits: "0", name: "RAM_1_RETENTIVE", desc: "Set on retentive mode for RAM_1 domain" }
      ]
    }

    { name:     "RAM_2_CLK_GATE",
      desc:     "Clock-gates the RAM_2 domain",
      resval:   "0x00000000"
      swaccess: "rw",
      hwaccess: "hro",
      fields: [
        { bits: "0", name: "RAM_2_CLK_GATE", desc: "Clock-gates the RAM_2 domain" }
      ]
    }

    { name:     "POWER_GATE_RAM_BLOCK_2_ACK",
      desc:     "Used by the ram 2 switch to ack the power manager",
      resval:   "0x00000000"
      swaccess: "ro",
      hwaccess: "hrw",
      fields: [
        { bits: "0", name: "POWER_GATE_RAM_BLOCK_2_ACK", desc: "Power Gate Ram Block 2 Ack Reg" }
      ]
    }

    { name:     "RAM_2_SWITCH",
      desc:     "Switch off the RAM_2 domain",
      resval:   "0x00000000"
      swaccess: "rw",
      hwaccess: "hro",
      fields: [
        { bits: "0", name: "RAM_2_SWITCH", desc: "Switch off RAM_2 domain" }
      ]
    }

    { name:     "RAM_2_WAIT_ACK_SWITCH_ON",
      desc:     "Wait for the RAM_2 domain switch ack",
      resval:   "0x00000000"
      swaccess: "rw",
      hwaccess: "hro",
      fields: [
        { bits: "0", name: "RAM_2_WAIT_ACK_SWITCH_ON", desc: "Wait RAM_2 domain switch ack" }
      ]
    }

    { name:     "RAM_2_ISO",
      desc:     "Set on the isolation of the RAM_2 domain",
      resval:   "0x00000000"
      swaccess: "rw",
      hwaccess: "hro",
      fields: [
        { bits: "0", name: "RAM_2_ISO", desc: "Set on isolation of RAM_2 domain" }
      ]
    }

    { name:     "RAM_2_RETENTIVE",
      desc:     "Set on retentive mode for the RAM_2 domain",
      resval:   "0x00000000"
      swaccess: "rw",
      hwaccess: "hro",
      fields: [
        { bits: "0", name: "RAM_2_RETENTIVE", desc: "Set on retentive mode for RAM_2 domain" }
      ]
    }

    { name:     "RAM_3_CLK_GATE",
      desc:     "Clock-gates the RAM_3 domain",
      resval:   "0x00000000"
      swaccess: "rw",
      hwaccess: "hro",
      fields: [
        { bits: "0", name: "RAM_3_CLK_GATE", desc: "Clock-gates the RAM_3 domain" }
      ]
    }

    { name:     "POWER_GATE_RAM_BLOCK_3_ACK",
      desc:     "Used by the ram 3 switch to ack the power manager",
      resval:   "0x00000000"
      swaccess: "ro",
      hwaccess: "hrw",
      fields: [
        { bits: "0", name: "POWER_GATE_RAM_BLOCK_3_ACK", desc: "Power Gate Ram Block 3 Ack Reg" }
      ]
    }

    { name:     "RAM_3_SWITCH",
      desc:     "Switch off the RAM_3 domain",
      resval:   "0x00000000"
      swaccess: "rw",
      hwaccess: "hro",
      fields: [
        { bits: "0", name: "RAM_3_SWITCH", desc: "Switch off RAM_3 domain" }
      ]
    }

    { name:     "RAM_3_WAIT_ACK_SWITCH_ON",
      desc:     "Wait for the RAM_3 domain switch ack",
      resval:   "0x00000000"
      swaccess: "rw",
      hwaccess: "hro",
      fields: [
        { bits: "0", name: "RAM_3_WAIT_ACK_SWITCH_ON", desc: "Wait RAM_3 domain switch ack" }
      ]
    }

    { name:     "RAM_3_ISO",
      desc:     "Set on the isolation of the RAM_3 domain",
      resval:   "0x00000000"
      swaccess: "rw",
      hwaccess: "hro",
      fields: [
        { bits: "0", name: "RAM_3_ISO", desc: "Set on isolation of RAM_3 domain" }
      ]
    }

    { name:     "RAM_3_RETENTIVE",
      desc:     "Set on retentive mode for the RAM_3 domain",
      resval:   "0x00000000"
      swaccess: "rw",
      hwaccess: "hro",
      fields: [
        { bits: "0", name: "RAM_3_RETENTIVE", desc: "Set on retentive mode for RAM_3 domain" }
      ]
    }

    { name:     "RAM_4_CLK_GATE",
      desc:     "Clock-gates the RAM_4 domain",
      resval:   "0x00000000"
      swaccess: "rw",
      hwaccess: "hro",
      fields: [
        { bits: "0", name: "RAM_4_CLK_GATE", desc: "Clock-gates the RAM_4 domain" }
      ]
    }

    { name:     "POWER_GATE_RAM_BLOCK_4_ACK",
      desc:     "Used by the ram 4 switch to ack the power manager",
      resval:   "0x00000000"
      swaccess: "ro",
      hwaccess: "hrw",
      fields: [
        { bits: "0", name: "POWER_GATE_RAM_BLOCK_4_ACK", desc: "Power Gate Ram Block 4 Ack Reg" }
      ]
    }

    { name:     "RAM_4_SWITCH",
      desc:     "Switch off the RAM_4 domain",
      resval:   "0x00000000"
      swaccess: "rw",
      hwaccess: "hro",
      fields: [
        { bits: "0", name: "RAM_4_SWITCH", desc: "Switch off RAM_4 domain" }
      ]
    }

    { name:     "RAM_4_WAIT_ACK_SWITCH_ON",
      desc:     "Wait for the RAM_4 domain switch ack",
      resval:   "0x00000000"
      swaccess: "rw",
      hwaccess: "hro",
      fields: [
        { bits: "0", name: "RAM_4_WAIT_ACK_SWITCH_ON", desc: "Wait RAM_4 domain switch ack" }
      ]
    }

    { name:     "RAM_4_ISO",
      desc:     "Set on the isolation of the RAM_4 domain",
      resval:   "0x00000000"
      swaccess: "rw",
      hwaccess: "hro",
      fields: [
        { bits: "0", name: "RAM_4_ISO", desc: "Set on isolation of RAM_4 domain" }
      ]
    }

    { name:     "RAM_4_RETENTIVE",
      desc:     "Set on retentive mode for the RAM_4 domain",
      resval:   "0x00000000"
      swaccess: "rw",
      hwaccess: "hro",
      fields: [
        { bits: "0", name: "RAM_4_RETENTIVE", desc: "Set on retentive mode for RAM_4 domain" }
      ]
    }

    { name:     "RAM_5_CLK_GATE",
      desc:     "Clock-gates the RAM_5 domain",
      resval:   "0x00000000"
      swaccess: "rw",
      hwaccess: "hro",
      fields: [
        { bits: "0", name: "RAM_5_CLK_GATE", desc: "Clock-gates the RAM_5 domain" }
      ]
    }

    { name:     "POWER_GATE_RAM_BLOCK_5_ACK",
      desc:     "Used by the ram 5 switch to ack the power manager",
      resval:   "0x00000000"
      swaccess: "ro",
      hwaccess: "hrw",
      fields: [
        { bits: "0", name: "POWER_GATE_RAM_BLOCK_5_ACK", desc: "Power Gate Ram Block 5 Ack Reg" }
      ]
    }

    { name:     "RAM_5_SWITCH",
      desc:     "Switch off the RAM_5 domain",
      resval:   "0x00000000"
      swaccess: "rw",
      hwaccess: "hro",
      fields: [
        { bits: "0", name: "RAM_5_SWITCH", desc: "Switch off RAM_5 domain" }
      ]
    }

    { name:     "RAM_5_WAIT_ACK_SWITCH_ON",
      desc:     "Wait for the RAM_5 domain switch ack",
      resval:   "0x00000000"
      swaccess: "rw",
      hwaccess: "hro",
      fields: [
        { bits: "0", name: "RAM_5_WAIT_ACK_SWITCH_ON", desc: "Wait RAM_5 domain switch ack" }
      ]
    }

    { name:     "RAM_5_ISO",
      desc:     "Set on the isolation of the RAM_5 domain",
      resval:   "0x00000000"
      swaccess: "rw",
      hwaccess: "hro",
      fields: [
        { bits: "0", name: "RAM_5_ISO", desc: "Set on isolation of RAM_5 domain" }
      ]
    }

    { name:     "RAM_5_RETENTIVE",
      desc:     "Set on retentive mode for the RAM_5 domain",
      resval:   "0x00000000"
      swaccess: "rw",
      hwaccess: "hro",
      fields: [
        { bits: "0", name: "RAM_5_RETENTIVE", desc: "Set on retentive mode for RAM_5 domain" }
      ]
    }

    { name:     "RAM_6_CLK_GATE",
      desc:     "Clock-gates the RAM_6 domain",
      resval:   "0x00000000"
      swaccess: "rw",
      hwaccess: "hro",
      fields: [
        { bits: "0", name: "RAM_6_CLK_GATE", desc: "Clock-gates the RAM_6 domain" }
      ]
    }

    { name:     "POWER_GATE_RAM_BLOCK_6_ACK",
      desc:     "Used by the ram 6 switch to ack the power manager",
      resval:   "0x00000000"
      swaccess: "ro",
      hwaccess: "hrw",
      fields: [
        { bits: "0", name: "POWER_GATE_RAM_BLOCK_6_ACK", desc: "Power Gate Ram Block 6 Ack Reg" }
      ]
    }

    { name:     "RAM_6_SWITCH",
      desc:     "Switch off the RAM_6 domain",
      resval:   "0x00000000"
      swaccess: "rw",
      hwaccess: "hro",
      fields: [
        { bits: "0", name: "RAM_6_SWITCH", desc: "Switch off RAM_6 domain" }
      ]
    }

    { name:     "RAM_6_WAIT_ACK_SWITCH_ON",
      desc:     "Wait for the RAM_6 domain switch ack",
      resval:   "0x00000000"
      swaccess: "rw",
      hwaccess: "hro",
      fields: [
        { bits: "0", name: "RAM_6_WAIT_ACK_SWITCH_ON", desc: "Wait RAM_6 domain switch ack" }
      ]
    }

    { name:     "RAM_6_ISO",
      desc:     "Set on the isolation of the RAM_6 domain",
      resval:   "0x00000000"
      swaccess: "rw",
      hwaccess: "hro",
      fields: [
        { bits: "0", name: "RAM_6_ISO", desc: "Set on isolation of RAM_6 domain" }
      ]
    }

    { name:     "RAM_6_RETENTIVE",
      desc:     "Set on retentive mode for the RAM_6 domain",
      resval:   "0x00000000"
      swaccess: "rw",
      hwaccess: "hro",
      fields: [
        { bits: "0", name: "RAM_6_RETENTIVE", desc: "Set on retentive mode for RAM_6 domain" }
      ]
    }

    { name:     "RAM_7_CLK_GATE",
      desc:     "Clock-gates the RAM_7 domain",
      resval:   "0x00000000"
      swaccess: "rw",
      hwaccess: "hro",
      fields: [
        { bits: "0", name: "RAM_7_CLK_GATE", desc: "Clock-gates the RAM_7 domain" }
      ]
    }

    { name:     "POWER_GATE_RAM_BLOCK_7_ACK",
      desc:     "Used by the ram 7 switch to ack the power manager",
      resval:   "0x00000000"
      swaccess: "ro",
      hwaccess: "hrw",
      fields: [
        { bits: "0", name: "POWER_GATE_RAM_BLOCK_7_ACK", desc: "Power Gate Ram Block 7 Ack Reg" }
      ]
    }

    { name:     "RAM_7_SWITCH",
      desc:     "Switch off the RAM_7 domain",
      resval:   "0x00000000"
      swaccess: "rw",
      hwaccess: "hro",
      fields: [
        { bits: "0", name: "RAM_7_SWITCH", desc: "Switch off RAM_7 domain" }
      ]
    }

    { name:     "RAM_7_WAIT_ACK_SWITCH_ON",
      desc:     "Wait for the RAM_7 domain switch ack",
      resval:   "0x00000000"
      swaccess: "rw",
      hwaccess: "hro",
      fields: [
        { bits: "0", name: "RAM_7_WAIT_ACK_SWITCH_ON", desc: "Wait RAM_7 domain switch ack" }
      ]
    }

    { name:     "RAM_7_ISO",
      desc:     "Set on the isolation of the RAM_7 domain",
      resval:   "0x00000000"
      swaccess: "rw",
      hwaccess: "hro",
      fields: [
        { bits: "0", name: "RAM_7_ISO", desc: "Set on isolation of RAM_7 domain" }
      ]
    }

    { name:     "RAM_7_RETENTIVE",
      desc:     "Set on retentive mode for the RAM_7 domain",
      resval:   "0x00000000"
      swaccess: "rw",
      hwaccess: "hro",
      fields: [
        { bits: "0", name: "RAM_7_RETENTIVE", desc: "Set on retentive mode for RAM_7 domain" }
      ]
    }

    { name:     "RAM_8_CLK_GATE",
      desc:     "Clock-gates the RAM_8 domain",
      resval:   "0x00000000"
      swaccess: "rw",
      hwaccess: "hro",
      fields: [
        { bits: "0", name: "RAM_8_CLK_GATE", desc: "Clock-gates the RAM_8 domain" }
      ]
    }

    { name:     "POWER_GATE_RAM_BLOCK_8_ACK",
      desc:     "Used by the ram 8 switch to ack the power manager",
      resval:   "0x00000000"
      swaccess: "ro",
      hwaccess: "hrw",
      fields: [
        { bits: "0", name: "POWER_GATE_RAM_BLOCK_8_ACK", desc: "Power Gate Ram Block 8 Ack Reg" }
      ]
    }

    { name:     "RAM_8_SWITCH",
      desc:     "Switch off the RAM_8 domain",
      resval:   "0x00000000"
      swaccess: "rw",
      hwaccess: "hro",
      fields: [
        { bits: "0", name: "RAM_8_SWITCH", desc: "Switch off RAM_8 domain" }
      ]
    }

    { name:     "RAM_8_WAIT_ACK_SWITCH_ON",
      desc:     "Wait for the RAM_8 domain switch ack",
      resval:   "0x00000000"
      swaccess: "rw",
      hwaccess: "hro",
      fields: [
        { bits: "0", name: "RAM_8_WAIT_ACK_SWITCH_ON", desc: "Wait RAM_8 domain switch ack" }
      ]
    }

    { name:     "RAM_8_ISO",
      desc:     "Set on the isolation of the RAM_8 domain",
      resval:   "0x00000000"
      swaccess: "rw",
      hwaccess: "hro",
      fields: [
        { bits: "0", name: "RAM_8_ISO", desc: "Set on isolation of RAM_8 domain" }
      ]
    }

    { name:     "RAM_8_RETENTIVE",
      desc:     "Set on retentive mode for the RAM_8 domain",
      resval:   "0x00000000"
      swaccess: "rw",
      hwaccess: "hro",
      fields: [
        { bits: "0", name: "RAM_8_RETENTIVE", desc: "Set on retentive mode for RAM_8 domain" }
      ]
    }

    { name:     "RAM_9_CLK_GATE",
      desc:     "Clock-gates the RAM_9 domain",
      resval:   "0x00000000"
      swaccess: "rw",
      hwaccess: "hro",
      fields: [
        { bits: "0", name: "RAM_9_CLK_GATE", desc: "Clock-gates the RAM_9 domain" }
      ]
    }

    { name:     "POWER_GATE_RAM_BLOCK_9_ACK",
      desc:     "Used by the ram 9 switch to ack the power manager",
      resval:   "0x00000000"
      swaccess: "ro",
      hwaccess: "hrw",
      fields: [
        { bits: "0", name: "POWER_GATE_RAM_BLOCK_9_ACK", desc: "Power Gate Ram Block 9 Ack Reg" }
      ]
    }

    { name:     "RAM_9_SWITCH",
      desc:     "Switch off the RAM_9 domain",
      resval:   "0x00000000"
      swaccess: "rw",
      hwaccess: "hro",
      fields: [
        { bits: "0", name: "RAM_9_SWITCH", desc: "Switch off RAM_9 domain" }
      ]
    }

    { name:     "RAM_9_WAIT_ACK_SWITCH_ON",
      desc:     "Wait for the RAM_9 domain switch ack",
      resval:   "0x00000000"
      swaccess: "rw",
      hwaccess: "hro",
      fields: [
        { bits: "0", name: "RAM_9_WAIT_ACK_SWITCH_ON", desc: "Wait RAM_9 domain switch ack" }
      ]
    }

    { name:     "RAM_9_ISO",
      desc:     "Set on the isolation of the RAM_9 domain",
      resval:   "0x00000000"
      swaccess: "rw",
      hwaccess: "hro",
      fields: [
        { bits: "0", name: "RAM_9_ISO", desc: "Set on isolation of RAM_9 domain" }
      ]
    }

    { name:     "RAM_9_RETENTIVE",
      desc:     "Set on retentive mode for the RAM_9 domain",
      resval:   "0x00000000"
      swaccess: "rw",
      hwaccess: "hro",
      fields: [
        { bits: "0", name: "RAM_9_RETENTIVE", desc: "Set on retentive mode for RAM_9 domain" }
      ]
    }

    { name:     "RAM_10_CLK_GATE",
      desc:     "Clock-gates the RAM_10 domain",
      resval:   "0x00000000"
      swaccess: "rw",
      hwaccess: "hro",
      fields: [
        { bits: "0", name: "RAM_10_CLK_GATE", desc: "Clock-gates the RAM_10 domain" }
      ]
    }

    { name:     "POWER_GATE_RAM_BLOCK_10_ACK",
      desc:     "Used by the ram 10 switch to ack the power manager",
      resval:   "0x00000000"
      swaccess: "ro",
      hwaccess: "hrw",
      fields: [
        { bits: "0", name: "POWER_GATE_RAM_BLOCK_10_ACK", desc: "Power Gate Ram Block 10 Ack Reg" }
      ]
    }

    { name:     "RAM_10_SWITCH",
      desc:     "Switch off the RAM_10 domain",
      resval:   "0x00000000"
      swaccess: "rw",
      hwaccess: "hro",
      fields: [
        { bits: "0", name: "RAM_10_SWITCH", desc: "Switch off RAM_10 domain" }
      ]
    }

    { name:     "RAM_10_WAIT_ACK_SWITCH_ON",
      desc:     "Wait for the RAM_10 domain switch ack",
      resval:   "0x00000000"
      swaccess: "rw",
      hwaccess: "hro",
      fields: [
        { bits: "0", name: "RAM_10_WAIT_ACK_SWITCH_ON", desc: "Wait RAM_10 domain switch ack" }
      ]
    }

    { name:     "RAM_10_ISO",
      desc:     "Set on the isolation of the RAM_10 domain",
      resval:   "0x00000000"
      swaccess: "rw",
      hwaccess: "hro",
      fields: [
        { bits: "0", name: "RAM_10_ISO", desc: "Set on isolation of RAM_10 domain" }
      ]
    }

    { name:     "RAM_10_RETENTIVE",
      desc:     "Set on retentive mode for the RAM_10 domain",
      resval:   "0x00000000"
      swaccess: "rw",
      hwaccess: "hro",
      fields: [
        { bits: "0", name: "RAM_10_RETENTIVE", desc: "Set on retentive mode for RAM_10 domain" }
      ]
    }

    { name:     "RAM_11_CLK_GATE",
      desc:     "Clock-gates the RAM_11 domain",
      resval:   "0x00000000"
      swaccess: "rw",
      hwaccess: "hro",
      fields: [
        { bits: "0", name: "RAM_11_CLK_GATE", desc: "Clock-gates the RAM_11 domain" }
      ]
    }

    { name:     "POWER_GATE_RAM_BLOCK_11_ACK",
      desc:     "Used by the ram 11 switch to ack the power manager",
      resval:   "0x00000000"
      swaccess: "ro",
      hwaccess: "hrw",
      fields: [
        { bits: "0", name: "POWER_GATE_RAM_BLOCK_11_ACK", desc: "Power Gate Ram Block 11 Ack Reg" }
      ]
    }

    { name:     "RAM_11_SWITCH",
      desc:     "Switch off the RAM_11 domain",
      resval:   "0x00000000"
      swaccess: "rw",
      hwaccess: "hro",
      fields: [
        { bits: "0", name: "RAM_11_SWITCH", desc: "Switch off RAM_11 domain" }
      ]
    }

    { name:     "RAM_11_WAIT_ACK_SWITCH_ON",
      desc:     "Wait for the RAM_11 domain switch ack",
      resval:   "0x00000000"
      swaccess: "rw",
      hwaccess: "hro",
      fields: [
        { bits: "0", name: "RAM_11_WAIT_ACK_SWITCH_ON", desc: "Wait RAM_11 domain switch ack" }
      ]
    }

    { name:     "RAM_11_ISO",
      desc:     "Set on the isolation of the RAM_11 domain",
      resval:   "0x00000000"
      swaccess: "rw",
      hwaccess: "hro",
      fields: [
        { bits: "0", name: "RAM_11_ISO", desc: "Set on isolation of RAM_11 domain" }
      ]
    }

    { name:     "RAM_11_RETENTIVE",
      desc:     "Set on retentive mode for the RAM_11 domain",
      resval:   "0x00000000"
      swaccess: "rw",
      hwaccess: "hro",
      fields: [
        { bits: "0", name: "RAM_11_RETENTIVE", desc: "Set on retentive mode for RAM_11 domain" }
      ]
    }

    { name:     "RAM_12_CLK_GATE",
      desc:     "Clock-gates the RAM_12 domain",
      resval:   "0x00000000"
      swaccess: "rw",
      hwaccess: "hro",
      fields: [
        { bits: "0", name: "RAM_12_CLK_GATE", desc: "Clock-gates the RAM_12 domain" }
      ]
    }

    { name:     "POWER_GATE_RAM_BLOCK_12_ACK",
      desc:     "Used by the ram 12 switch to ack the power manager",
      resval:   "0x00000000"
      swaccess: "ro",
      hwaccess: "hrw",
      fields: [
        { bits: "0", name: "POWER_GATE_RAM_BLOCK_12_ACK", desc: "Power Gate Ram Block 12 Ack Reg" }
      ]
    }

    { name:     "RAM_12_SWITCH",
      desc:     "Switch off the RAM_12 domain",
      resval:   "0x00000000"
      swaccess: "rw",
      hwaccess: "hro",
      fields: [
        { bits: "0", name: "RAM_12_SWITCH", desc: "Switch off RAM_12 domain" }
      ]
    }

    { name:     "RAM_12_WAIT_ACK_SWITCH_ON",
      desc:     "Wait for the RAM_12 domain switch ack",
      resval:   "0x00000000"
      swaccess: "rw",
      hwaccess: "hro",
      fields: [
        { bits: "0", name: "RAM_12_WAIT_ACK_SWITCH_ON", desc: "Wait RAM_12 domain switch ack" }
      ]
    }

    { name:     "RAM_12_ISO",
      desc:     "Set on the isolation of the RAM_12 domain",
      resval:   "0x00000000"
      swaccess: "rw",
      hwaccess: "hro",
      fields: [
        { bits: "0", name: "RAM_12_ISO", desc: "Set on isolation of RAM_12 domain" }
      ]
    }

    { name:     "RAM_12_RETENTIVE",
      desc:     "Set on retentive mode for the RAM_12 domain",
      resval:   "0x00000000"
      swaccess: "rw",
      hwaccess: "hro",
      fields: [
        { bits: "0", name: "RAM_12_RETENTIVE", desc: "Set on retentive mode for RAM_12 domain" }
      ]
    }

    { name:     "RAM_13_CLK_GATE",
      desc:     "Clock-gates the RAM_13 domain",
      resval:   "0x00000000"
      swaccess: "rw",
      hwaccess: "hro",
      fields: [
        { bits: "0", name: "RAM_13_CLK_GATE", desc: "Clock-gates the RAM_13 domain" }
      ]
    }

    { name:     "POWER_GATE_RAM_BLOCK_13_ACK",
      desc:     "Used by the ram 13 switch to ack the power manager",
      resval:   "0x00000000"
      swaccess: "ro",
      hwaccess: "hrw",
      fields: [
        { bits: "0", name: "POWER_GATE_RAM_BLOCK_13_ACK", desc: "Power Gate Ram Block 13 Ack Reg" }
      ]
    }

    { name:     "RAM_13_SWITCH",
      desc:     "Switch off the RAM_13 domain",
      resval:   "0x00000000"
      swaccess: "rw",
      hwaccess: "hro",
      fields: [
        { bits: "0", name: "RAM_13_SWITCH", desc: "Switch off RAM_13 domain" }
      ]
    }

    { name:     "RAM_13_WAIT_ACK_SWITCH_ON",
      desc:     "Wait for the RAM_13 domain switch ack",
      resval:   "0x00000000"
      swaccess: "rw",
      hwaccess: "hro",
      fields: [
        { bits: "0", name: "RAM_13_WAIT_ACK_SWITCH_ON", desc: "Wait RAM_13 domain switch ack" }
      ]
    }

    { name:     "RAM_13_ISO",
      desc:     "Set on the isolation of the RAM_13 domain",
      resval:   "0x00000000"
      swaccess: "rw",
      hwaccess: "hro",
      fields: [
        { bits: "0", name: "RAM_13_ISO", desc: "Set on isolation of RAM_13 domain" }
      ]
    }

    { name:     "RAM_13_RETENTIVE",
      desc:     "Set on retentive mode for the RAM_13 domain",
      resval:   "0x00000000"
      swaccess: "rw",
      hwaccess: "hro",
      fields: [
        { bits: "0", name: "RAM_13_RETENTIVE", desc: "Set on retentive mode for RAM_13 domain" }
      ]
    }

    { name:     "RAM_14_CLK_GATE",
      desc:     "Clock-gates the RAM_14 domain",
      resval:   "0x00000000"
      swaccess: "rw",
      hwaccess: "hro",
      fields: [
        { bits: "0", name: "RAM_14_CLK_GATE", desc: "Clock-gates the RAM_14 domain" }
      ]
    }

    { name:     "POWER_GATE_RAM_BLOCK_14_ACK",
      desc:     "Used by the ram 14 switch to ack the power manager",
      resval:   "0x00000000"
      swaccess: "ro",
      hwaccess: "hrw",
      fields: [
        { bits: "0", name: "POWER_GATE_RAM_BLOCK_14_ACK", desc: "Power Gate Ram Block 14 Ack Reg" }
      ]
    }

    { name:     "RAM_14_SWITCH",
      desc:     "Switch off the RAM_14 domain",
      resval:   "0x00000000"
      swaccess: "rw",
      hwaccess: "hro",
      fields: [
        { bits: "0", name: "RAM_14_SWITCH", desc: "Switch off RAM_14 domain" }
      ]
    }

    { name:     "RAM_14_WAIT_ACK_SWITCH_ON",
      desc:     "Wait for the RAM_14 domain switch ack",
      resval:   "0x00000000"
      swaccess: "rw",
      hwaccess: "hro",
      fields: [
        { bits: "0", name: "RAM_14_WAIT_ACK_SWITCH_ON", desc: "Wait RAM_14 domain switch ack" }
      ]
    }

    { name:     "RAM_14_ISO",
      desc:     "Set on the isolation of the RAM_14 domain",
      resval:   "0x00000000"
      swaccess: "rw",
      hwaccess: "hro",
      fields: [
        { bits: "0", name: "RAM_14_ISO", desc: "Set on isolation of RAM_14 domain" }
      ]
    }

    { name:     "RAM_14_RETENTIVE",
      desc:     "Set on retentive mode for the RAM_14 domain",
      resval:   "0x00000000"
      swaccess: "rw",
      hwaccess: "hro",
      fields: [
        { bits: "0", name: "RAM_14_RETENTIVE", desc: "Set on retentive mode for RAM_14 domain" }
      ]
    }

    { name:     "RAM_15_CLK_GATE",
      desc:     "Clock-gates the RAM_15 domain",
      resval:   "0x00000000"
      swaccess: "rw",
      hwaccess: "hro",
      fields: [
        { bits: "0", name: "RAM_15_CLK_GATE", desc: "Clock-gates the RAM_15 domain" }
      ]
    }

    { name:     "POWER_GATE_RAM_BLOCK_15_ACK",
      desc:     "Used by the ram 15 switch to ack the power manager",
      resval:   "0x00000000"
      swaccess: "ro",
      hwaccess: "hrw",
      fields: [
        { bits: "0", name: "POWER_GATE_RAM_BLOCK_15_ACK", desc: "Power Gate Ram Block 15 Ack Reg" }
      ]
    }

    { name:     "RAM_15_SWITCH",
      desc:     "Switch off the RAM_15 domain",
      resval:   "0x00000000"
      swaccess: "rw",
      hwaccess: "hro",
      fields: [
        { bits: "0", name: "RAM_15_SWITCH", desc: "Switch off RAM_15 domain" }
      ]
    }

    { name:     "RAM_15_WAIT_ACK_SWITCH_ON",
      desc:     "Wait for the RAM_15 domain switch ack",
      resval:   "0x00000000"
      swaccess: "rw",
      hwaccess: "hro",
      fields: [
        { bits: "0", name: "RAM_15_WAIT_ACK_SWITCH_ON", desc: "Wait RAM_15 domain switch ack" }
      ]
    }

    { name:     "RAM_15_ISO",
      desc:     "Set on the isolation of the RAM_15 domain",
      resval:   "0x00000000"
      swaccess: "rw",
      hwaccess: "hro",
      fields: [
        { bits: "0", name: "RAM_15_ISO", desc: "Set on isolation of RAM_15 domain" }
      ]
    }

    { name:     "RAM_15_RETENTIVE",
      desc:     "Set on retentive mode for the RAM_15 domain",
      resval:   "0x00000000"
      swaccess: "rw",
      hwaccess: "hro",
      fields: [
        { bits: "0", name: "RAM_15_RETENTIVE", desc: "Set on retentive mode for RAM_15 domain" }
      ]
    }

    { name:     "EXTERNAL_0_CLK_GATE",
      desc:     "Clock-gates the EXTERNAL_0 domain",
      resval:   "0x00000000"
      swaccess: "rw",
      hwaccess: "hro",
      fields: [
        { bits: "0", name: "EXTERNAL_0_CLK_GATE", desc: "Clock-gates the EXTERNAL_0 domain" }
      ]
    }

    { name:     "POWER_GATE_EXTERNAL_0_ACK",
      desc:     "Used by the external 0 switch to ack the power manager",
      resval:   "0x00000000"
      swaccess: "ro",
      hwaccess: "hrw",
      fields: [
        { bits: "0", name: "POWER_GATE_EXTERNAL_0_ACK", desc: "Power Gate External 0 Ack Reg" }
      ]
    }

    { name:     "EXTERNAL_0_RESET",
      desc:     "Reset the EXTERNAL_0 domain",
      resval:   "0x00000000"
      swaccess: "rw",
      hwaccess: "hro",
      fields: [
        { bits: "0", name: "EXTERNAL_0_RESET", desc: "Reset EXTERNAL_0 domain" }
      ]
    }

    { name:     "EXTERNAL_0_SWITCH",
      desc:     "Switch off the EXTERNAL_0 domain",
      resval:   "0x00000000"
      swaccess: "rw",
      hwaccess: "hro",
      fields: [
        { bits: "0", name: "EXTERNAL_0_SWITCH", desc: "Switch off EXTERNAL_0 domain" }
      ]
    }

    { name:     "EXTERNAL_0_WAIT_ACK_SWITCH_ON",
      desc:     "Wait for the EXTERNAL_0 domain switch ack",
      resval:   "0x00000000"
      swaccess: "rw",
      hwaccess: "hro",
      fields: [
        { bits: "0", name: "EXTERNAL_0_WAIT_ACK_SWITCH_ON", desc: "Wait EXTERNAL_0 domain switch ack" }
      ]
    }

    { name:     "EXTERNAL_0_ISO",
      desc:     "Set on the isolation of the EXTERNAL_0 domain",
      resval:   "0x00000000"
      swaccess: "rw",
      hwaccess: "hro",
      fields: [
        { bits: "0", name: "EXTERNAL_0_ISO", desc: "Set on isolation of EXTERNAL_0 domain" }
      ]
    }

    { name:     "EXTERNAL_RAM_0_RETENTIVE",
      desc:     "Set on retentive mode for external RAM_0 domain",
      resval:   "0x00000000"
      swaccess: "rw",
      hwaccess: "hro",
      fields: [
        { bits: "0", name: "EXTERNAL_RAM_0_RETENTIVE", desc: "Set on retentive mode of external RAM_0 domain" }
      ]
    }

    { name:     "MONITOR_POWER_GATE_CORE",
      desc:     "Used to monitor the signals to power gate core",
      resval:   "0x00000000"
      swaccess: "ro",
      hwaccess: "hwo",
      fields: [
        { bits: "2:0", name: "MONITOR_POWER_GATE_CORE", desc: "Monitor Signals Power Gate Core Reg" }
      ]
    }

    { name:     "MONITOR_POWER_GATE_PERIPH",
      desc:     "Used to monitor the signals to power gate periph",
      resval:   "0x00000000"
      swaccess: "ro",
      hwaccess: "hwo",
      fields: [
        { bits: "2:0", name: "MONITOR_POWER_GATE_PERIPH", desc: "Monitor Signals Power Gate Periph Reg" }
      ]
    }

    { name:     "MONITOR_POWER_GATE_RAM_BLOCK_0",
      desc:     "Used to monitor the signals to power gate ram block 0",
      resval:   "0x00000000"
      swaccess: "ro",
      hwaccess: "hwo",
      fields: [
        { bits: "1:0", name: "MONITOR_POWER_GATE_RAM_BLOCK_0", desc: "Monitor Signals Power Gate Ram Block 0 Reg" }
      ]
    }

    { name:     "MONITOR_POWER_GATE_RAM_BLOCK_1",
      desc:     "Used to monitor the signals to power gate ram block 1",
      resval:   "0x00000000"
      swaccess: "ro",
      hwaccess: "hwo",
      fields: [
        { bits: "1:0", name: "MONITOR_POWER_GATE_RAM_BLOCK_1", desc: "Monitor Signals Power Gate Ram Block 1 Reg" }
      ]
    }

    { name:     "MONITOR_POWER_GATE_RAM_BLOCK_2",
      desc:     "Used to monitor the signals to power gate ram block 2",
      resval:   "0x00000000"
      swaccess: "ro",
      hwaccess: "hwo",
      fields: [
        { bits: "1:0", name: "MONITOR_POWER_GATE_RAM_BLOCK_2", desc: "Monitor Signals Power Gate Ram Block 2 Reg" }
      ]
    }

    { name:     "MONITOR_POWER_GATE_RAM_BLOCK_3",
      desc:     "Used to monitor the signals to power gate ram block 3",
      resval:   "0x00000000"
      swaccess: "ro",
      hwaccess: "hwo",
      fields: [
        { bits: "1:0", name: "MONITOR_POWER_GATE_RAM_BLOCK_3", desc: "Monitor Signals Power Gate Ram Block 3 Reg" }
      ]
    }

    { name:     "MONITOR_POWER_GATE_RAM_BLOCK_4",
      desc:     "Used to monitor the signals to power gate ram block 4",
      resval:   "0x00000000"
      swaccess: "ro",
      hwaccess: "hwo",
      fields: [
        { bits: "1:0", name: "MONITOR_POWER_GATE_RAM_BLOCK_4", desc: "Monitor Signals Power Gate Ram Block 4 Reg" }
      ]
    }

    { name:     "MONITOR_POWER_GATE_RAM_BLOCK_5",
      desc:     "Used to monitor the signals to power gate ram block 5",
      resval:   "0x00000000"
      swaccess: "ro",
      hwaccess: "hwo",
      fields: [
        { bits: "1:0", name: "MONITOR_POWER_GATE_RAM_BLOCK_5", desc: "Monitor Signals Power Gate Ram Block 5 Reg" }
      ]
    }

    { name:     "MONITOR_POWER_GATE_RAM_BLOCK_6",
      desc:     "Used to monitor the signals to power gate ram block 6",
      resval:   "0x00000000"
      swaccess: "ro",
      hwaccess: "hwo",
      fields: [
        { bits: "1:0", name: "MONITOR_POWER_GATE_RAM_BLOCK_6", desc: "Monitor Signals Power Gate Ram Block 6 Reg" }
      ]
    }

    { name:     "MONITOR_POWER_GATE_RAM_BLOCK_7",
      desc:     "Used to monitor the signals to power gate ram block 7",
      resval:   "0x00000000"
      swaccess: "ro",
      hwaccess: "hwo",
      fields: [
        { bits: "1:0", name: "MONITOR_POWER_GATE_RAM_BLOCK_7", desc: "Monitor Signals Power Gate Ram Block 7 Reg" }
      ]
    }

    { name:     "MONITOR_POWER_GATE_RAM_BLOCK_8",
      desc:     "Used to monitor the signals to power gate ram block 8",
      resval:   "0x00000000"
      swaccess: "ro",
      hwaccess: "hwo",
      fields: [
        { bits: "1:0", name: "MONITOR_POWER_GATE_RAM_BLOCK_8", desc: "Monitor Signals Power Gate Ram Block 8 Reg" }
      ]
    }

    { name:     "MONITOR_POWER_GATE_RAM_BLOCK_9",
      desc:     "Used to monitor the signals to power gate ram block 9",
      resval:   "0x00000000"
      swaccess: "ro",
      hwaccess: "hwo",
      fields: [
        { bits: "1:0", name: "MONITOR_POWER_GATE_RAM_BLOCK_9", desc: "Monitor Signals Power Gate Ram Block 9 Reg" }
      ]
    }

    { name:     "MONITOR_POWER_GATE_RAM_BLOCK_10",
      desc:     "Used to monitor the signals to power gate ram block 10",
      resval:   "0x00000000"
      swaccess: "ro",
      hwaccess: "hwo",
      fields: [
        { bits: "1:0", name: "MONITOR_POWER_GATE_RAM_BLOCK_10", desc: "Monitor Signals Power Gate Ram Block 10 Reg" }
      ]
    }

    { name:     "MONITOR_POWER_GATE_RAM_BLOCK_11",
      desc:     "Used to monitor the signals to power gate ram block 11",
      resval:   "0x00000000"
      swaccess: "ro",
      hwaccess: "hwo",
      fields: [
        { bits: "1:0", name: "MONITOR_POWER_GATE_RAM_BLOCK_11", desc: "Monitor Signals Power Gate Ram Block 11 Reg" }
      ]
    }

    { name:     "MONITOR_POWER_GATE_RAM_BLOCK_12",
      desc:     "Used to monitor the signals to power gate ram block 12",
      resval:   "0x00000000"
      swaccess: "ro",
      hwaccess: "hwo",
      fields: [
        { bits: "1:0", name: "MONITOR_POWER_GATE_RAM_BLOCK_12", desc: "Monitor Signals Power Gate Ram Block 12 Reg" }
      ]
    }

    { name:     "MONITOR_POWER_GATE_RAM_BLOCK_13",
      desc:     "Used to monitor the signals to power gate ram block 13",
      resval:   "0x00000000"
      swaccess: "ro",
      hwaccess: "hwo",
      fields: [
        { bits: "1:0", name: "MONITOR_POWER_GATE_RAM_BLOCK_13", desc: "Monitor Signals Power Gate Ram Block 13 Reg" }
      ]
    }

    { name:     "MONITOR_POWER_GATE_RAM_BLOCK_14",
      desc:     "Used to monitor the signals to power gate ram block 14",
      resval:   "0x00000000"
      swaccess: "ro",
      hwaccess: "hwo",
      fields: [
        { bits: "1:0", name: "MONITOR_POWER_GATE_RAM_BLOCK_14", desc: "Monitor Signals Power Gate Ram Block 14 Reg" }
      ]
    }

    { name:     "MONITOR_POWER_GATE_RAM_BLOCK_15",
      desc:     "Used to monitor the signals to power gate ram block 15",
      resval:   "0x00000000"
      swaccess: "ro",
      hwaccess: "hwo",
      fields: [
        { bits: "1:0", name: "MONITOR_POWER_GATE_RAM_BLOCK_15", desc: "Monitor Signals Power Gate Ram Block 15 Reg" }
      ]
    }

    { name:     "MONITOR_POWER_GATE_EXTERNAL_0",
      desc:     "Used to monitor the signals to power gate external 0",
      resval:   "0x00000000"
      swaccess: "ro",
      hwaccess: "hwo",
      fields: [
        { bits: "2:0", name: "MONITOR_POWER_GATE_EXTERNAL_0", desc: "Monitor Signals Power Gate External 0 Reg" }
      ]
    }

    { name:     "MASTER_CPU_FORCE_SWITCH_OFF",
      desc:     "Used to force core switch off",
      resval:   "0x00000000"
      swaccess: "rw",
      hwaccess: "hro",
      fields: [
        { bits: "0", name: "MASTER_CPU_FORCE_SWITCH_OFF", desc: "Force Core Switch Off Reg, used by JTAG" }
      ]
    }

    { name:     "MASTER_CPU_FORCE_SWITCH_ON",
      desc:     "Used to force core switch on",
      resval:   "0x00000000"
      swaccess: "rw",
      hwaccess: "hro",
      fields: [
        { bits: "0", name: "MASTER_CPU_FORCE_SWITCH_ON", desc: "Force Core Switch On Reg, used by JTAG" }
      ]
    }

    { name:     "MASTER_CPU_FORCE_RESET_ASSERT",
      desc:     "Used to force core reset assert",
      resval:   "0x00000000"
      swaccess: "rw",
      hwaccess: "hro",
      fields: [
        { bits: "0", name: "MASTER_CPU_FORCE_RESET_ASSERT", desc: "Force Core Reset Assert Reg, used by JTAG" }
      ]
    }

    { name:     "MASTER_CPU_FORCE_RESET_DEASSERT",
      desc:     "Used to force core reset deassert",
      resval:   "0x00000000"
      swaccess: "rw",
      hwaccess: "hro",
      fields: [
        { bits: "0", name: "MASTER_CPU_FORCE_RESET_DEASSERT", desc: "Force Core Reset Deassert Reg, used by JTAG" }
      ]
    }

    { name:     "MASTER_CPU_FORCE_ISO_OFF",
      desc:     "Used to force core iso off",
      resval:   "0x00000000"
      swaccess: "rw",
      hwaccess: "hro",
      fields: [
        { bits: "0", name: "MASTER_CPU_FORCE_ISO_OFF", desc: "Force Core Iso Off Reg, used by JTAG" }
      ]
    }

    { name:     "MASTER_CPU_FORCE_ISO_ON",
      desc:     "Used to force core iso on",
      resval:   "0x00000000"
      swaccess: "rw",
      hwaccess: "hro",
      fields: [
        { bits: "0", name: "MASTER_CPU_FORCE_ISO_ON", desc: "Force Core Iso On Reg, used by JTAG" }
      ]
    }

   ]
}
